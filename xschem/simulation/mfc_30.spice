** sch_path: /home/ttuser/Mfcs/mfc_30/xschem/mfc_30.sch
.subckt mfc_30 gate sbd
*.PININFO gate:I sbd:O
XM2 sbd gate sbd sbd sky130_fd_pr__nfet_01v8 L=1.2 W=0.42 nf=1 m=1
.ends
.end
